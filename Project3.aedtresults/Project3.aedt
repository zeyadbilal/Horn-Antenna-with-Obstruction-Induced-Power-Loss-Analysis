# Ansys Electronics Desktop project, version 2016.2
materials:
  vacuum: permittivity=1

design HFSSDesign1 (HFSS, DrivenModal, model units in)
geometry:
  waveguide [vacuum] = box(corner=(-0.795in, -0.3975in, 0in), size=(1.59in, 0.795in, 1in))
  face = rectangle(corner=(-3.975in, -1.9875in, 5in), x_size=7.95in, y_size=3.975in)
  waveguide_ObjectFromFace1 = object_from(waveguide.face(+z))
  face_ObjectFromFace1 = object_from(face.face(at (0, 0, 5)))
  waveguide_ObjectFromFace1.connect(face_ObjectFromFace1)
  waveguide_ObjectFromFace1.uncover_faces(FacesToUncover=face_ObjectFromFace1.face)
  face.uncover_faces(FacesToUncover=face.face(at (0, 0, 5)))
  waveguide_ObjectFromFace1.uncover_faces(FacesToUncover=waveguide.face(1 of 1))
  waveguide.uncover_faces(FacesToUncover=waveguide.face(+z))
  waveguide.unite(waveguide_ObjectFromFace1)
  Radiation_Box [vacuum] = box(corner=(-4.5in, -2.3in, 0in), size=(8.8in, 4.4in, 15in))
boundaries and excitations:
  PerfE1: Perfect E Objects=waveguide
  Rad1: Radiation Objects=Radiation_Box
  1: Wave Port Faces=waveguide.face(-z) NumModes=1 Modes{Mode1{IntLine{middle of waveguide.edge(7 of 12) -> middle of waveguide.edge(5 of 12)} CharImp=Zpi}}
setups:
  Setup1: HfssDriven Frequency=5GHz MaxDeltaS=0.02 MaximumPasses=25 MinimumPasses=1 MinimumConvergedPasses=1 PercentRefinement=30 BasisOrder=1 PortAccuracy=2
    sweep Sweep: 4GHz to 8GHz step 0.02GHz; Type=Interpolating InterpTolerance=0.5 InterpMaxSolns=250 InterpUsePortImped=false PassivityErrorTolerance=0.0001
source amplitudes:
  1:1: 1W 0deg
radiation setups:
  Infinite Sphere1: Infinite Sphere Theta=-180deg..180deg step 1deg Phi=0deg..180deg step 1deg
reports:
  XY Plot 1: dB(S(1,1)) vs Freq on Setup1 : Sweep; markers m1 at 4.54GHz, m2 at 4.8GHz
  XY Plot 2: re(Z(1,1)) vs Freq on Setup1 : Sweep; markers m1 at 4.38GHz, m2 at 4.78GHz, m3 at 5.28GHz
  Gain: dB(GainTotal) vs Phi, Theta on Setup1 : LastAdaptive, Infinite Sphere1 [Freq=5GHz]
